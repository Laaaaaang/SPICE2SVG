* Voltage Divider
*
*     VIN ---[R1 10k]---+--- VOUT
*                       |
*                     [R2 10k]
*                       |
*                      GND
*

R1 VIN VOUT 10k
R2 VOUT 0 10k

.end
